{
    name: "hwpe_buffer",
    clock_primary: "clk_i",
    reset_primary: "rst_ni",
    bus_interfaces: [ { protocol: "reg_iface", direction: "device" } ],
    regwidth: "32",
    registers: [
        { name: "DATA_IN",
          desc: "Inputs for hwpe_buffer",
          swaccess: "wo",
          fields: [
              { bits: "31:0"
              }
          ],
        },
        { name: "DATA_OUT",
          desc: "Output for hwpe_buffer",
          swaccess: "ro",
          hwaccess: "hwo",
          hwext: "true",
          fields: [
              { bits: "31:0"
              }
          ],
        }
    ],
}