{
    name: "hwpe_buffer",
    clock_primary: "clk_i",
    reset_primary: "rst_ni",
    bus_interfaces: [ { protocol: "reg_iface", direction: "device" } ],
    regwidth: "32",
    registers: [
        { multireg:
          { name: "DATA_IN",
            desc: "Inputs for hwpe_buffer",
            count: "32",
            cname: "DATA_IN",
            swaccess: "wo",
            hwext: "false",
            fields: [
                { bits: "31:0"
                }
            ],
          }
        },
        { multireg:
          { name: "DATA_OUT",
            desc: "Output for hwpe_buffer",
            count: "32",
            cname: "DATA_OUT",
            swaccess: "ro",
            hwaccess: "hwo",
            hwext: "true",
            fields: [
                { bits: "31:0"
                }
            ],
          }
        }
    ]
}